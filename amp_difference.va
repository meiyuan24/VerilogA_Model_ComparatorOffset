// VerilogA for verilogA, amp_difference, veriloga

`include "constants.vams"
`include "disciplines.vams"

module amp_difference(siginp, siginn, out);

input siginp, siginn;
output out;
electrical siginp, siginn, out;
parameter real gain = 1;
parameter sigin_offset = 0;
parameter real vcm = 0.6;

	analog begin
		V(out) <+ gain*(V(siginp)-V(siginn)- sigin_offset)+vcm;
	end
endmodule
